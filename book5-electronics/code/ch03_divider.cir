* ch03_divider.cir -- 5 V -> 3.3 V divider, operating point
V1 1 0 DC 5
R1 1 2 1000
R2 2 0 2000
.op
.end
