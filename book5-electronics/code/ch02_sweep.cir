* ch02_sweep.cir -- dc sweep: LED-circuit current vs supply voltage, 0 to 5 V
* produces the knee-and-ramp curve of figure 2.4
V1 1 0 DC 0
R1 1 2 200
D1 2 0 LEDMOD
.model LEDMOD D (IS=1e-19 N=2 BV=100)
.control
dc v1 0 5 0.05
let iload = -i(v1)
set filetype=ascii
wrdata ch02_sweep.dat iload
.endc
.end
