* ch03_twoloop.cir -- two sources feeding one node through resistors
* worked example 3.2: node voltage by hand vs ngspice
V1 1 0 DC 12
V2 2 0 DC 6
R1 1 3 100
R2 2 3 220
R3 3 0 470
.op
.end
